.param meas_0tsw=(0*tsw+3.25*tclk2)
.param meas_1tsw=(1*tsw+3.25*tclk2)
.param meas_2tsw=(2*tsw+3.25*tclk2)
.param meas_3tsw=(3*tsw+3.25*tclk2)
.param meas_4tsw=(4*tsw+3.25*tclk2)
.param meas_5tsw=(5*tsw+3.25*tclk2)
.param meas_6tsw=(6*tsw+3.25*tclk2)
.param meas_7tsw=(7*tsw+3.25*tclk2)
.param meas_8tsw=(8*tsw+3.25*tclk2)
.param meas_9tsw=(9*tsw+3.25*tclk2)
.param meas_10tsw=(10*tsw+3.25*tclk2)
.param meas_11tsw=(11*tsw+3.25*tclk2)
.param meas_12tsw=(12*tsw+3.25*tclk2)
.param meas_13tsw=(13*tsw+3.25*tclk2)
.param meas_14tsw=(14*tsw+3.25*tclk2)
.param meas_15tsw=(15*tsw+3.25*tclk2)
.param meas_16tsw=(16*tsw+3.25*tclk2)
.param meas_17tsw=(17*tsw+3.25*tclk2)
.param meas_18tsw=(18*tsw+3.25*tclk2)
.param meas_19tsw=(19*tsw+3.25*tclk2)
.param meas_20tsw=(20*tsw+3.25*tclk2)
.param meas_21tsw=(21*tsw+3.25*tclk2)
.param meas_22tsw=(22*tsw+3.25*tclk2)
.param meas_23tsw=(23*tsw+3.25*tclk2)
.param meas_24tsw=(24*tsw+3.25*tclk2)
.param meas_25tsw=(25*tsw+3.25*tclk2)
.param meas_26tsw=(26*tsw+3.25*tclk2)
.param meas_27tsw=(27*tsw+3.25*tclk2)
.param meas_28tsw=(28*tsw+3.25*tclk2)
.param meas_29tsw=(29*tsw+3.25*tclk2)
.param meas_30tsw=(30*tsw+3.25*tclk2)
.param meas_31tsw=(31*tsw+3.25*tclk2)
.param lvdd2=(0.5*lvdd)

.meas tran tdel00 TRIG V(IN) VAL=lvdd2 TD=(meas_0tsw) RISE=0 TARG V(OUT) VAL=lvdd2 TD=(meas_0tsw) RISE=0
.meas tran tdel01 TRIG V(IN) VAL=lvdd2 TD=(meas_1tsw) RISE=0 TARG V(OUT) VAL=lvdd2 TD=(meas_1tsw) RISE=0
.meas tran tdel02 TRIG V(IN) VAL=lvdd2 TD=(meas_2tsw) RISE=0 TARG V(OUT) VAL=lvdd2 TD=(meas_2tsw) RISE=0
.meas tran tdel03 TRIG V(IN) VAL=lvdd2 TD=(meas_3tsw) RISE=0 TARG V(OUT) VAL=lvdd2 TD=(meas_3tsw) RISE=0
.meas tran tdel04 TRIG V(IN) VAL=lvdd2 TD=(meas_4tsw) RISE=0 TARG V(OUT) VAL=lvdd2 TD=(meas_4tsw) RISE=0
.meas tran tdel05 TRIG V(IN) VAL=lvdd2 TD=(meas_5tsw) RISE=0 TARG V(OUT) VAL=lvdd2 TD=(meas_5tsw) RISE=0
.meas tran tdel06 TRIG V(IN) VAL=lvdd2 TD=(meas_6tsw) RISE=0 TARG V(OUT) VAL=lvdd2 TD=(meas_6tsw) RISE=0
.meas tran tdel07 TRIG V(IN) VAL=lvdd2 TD=(meas_7tsw) RISE=0 TARG V(OUT) VAL=lvdd2 TD=(meas_7tsw) RISE=0
.meas tran tdel08 TRIG V(IN) VAL=lvdd2 TD=(meas_8tsw) RISE=0 TARG V(OUT) VAL=lvdd2 TD=(meas_8tsw) RISE=0
.meas tran tdel09 TRIG V(IN) VAL=lvdd2 TD=(meas_9tsw) RISE=0 TARG V(OUT) VAL=lvdd2 TD=(meas_9tsw) RISE=0
.meas tran tdel10 TRIG V(IN) VAL=lvdd2 TD=(meas_10tsw) RISE=0 TARG V(OUT) VAL=lvdd2 TD=(meas_10tsw) RISE=0
.meas tran tdel11 TRIG V(IN) VAL=lvdd2 TD=(meas_11tsw) RISE=0 TARG V(OUT) VAL=lvdd2 TD=(meas_11tsw) RISE=0
.meas tran tdel12 TRIG V(IN) VAL=lvdd2 TD=(meas_12tsw) RISE=0 TARG V(OUT) VAL=lvdd2 TD=(meas_12tsw) RISE=0
.meas tran tdel13 TRIG V(IN) VAL=lvdd2 TD=(meas_13tsw) RISE=0 TARG V(OUT) VAL=lvdd2 TD=(meas_13tsw) RISE=0
.meas tran tdel14 TRIG V(IN) VAL=lvdd2 TD=(meas_14tsw) RISE=0 TARG V(OUT) VAL=lvdd2 TD=(meas_14tsw) RISE=0
.meas tran tdel15 TRIG V(IN) VAL=lvdd2 TD=(meas_15tsw) RISE=0 TARG V(OUT) VAL=lvdd2 TD=(meas_15tsw) RISE=0
.meas tran tdel16 TRIG V(IN) VAL=lvdd2 TD=(meas_16tsw) RISE=0 TARG V(OUT) VAL=lvdd2 TD=(meas_16tsw) RISE=0
.meas tran tdel17 TRIG V(IN) VAL=lvdd2 TD=(meas_17tsw) RISE=0 TARG V(OUT) VAL=lvdd2 TD=(meas_17tsw) RISE=0
.meas tran tdel18 TRIG V(IN) VAL=lvdd2 TD=(meas_18tsw) RISE=0 TARG V(OUT) VAL=lvdd2 TD=(meas_18tsw) RISE=0
.meas tran tdel19 TRIG V(IN) VAL=lvdd2 TD=(meas_19tsw) RISE=0 TARG V(OUT) VAL=lvdd2 TD=(meas_19tsw) RISE=0
.meas tran tdel20 TRIG V(IN) VAL=lvdd2 TD=(meas_20tsw) RISE=0 TARG V(OUT) VAL=lvdd2 TD=(meas_20tsw) RISE=0
.meas tran tdel21 TRIG V(IN) VAL=lvdd2 TD=(meas_21tsw) RISE=0 TARG V(OUT) VAL=lvdd2 TD=(meas_21tsw) RISE=0
.meas tran tdel22 TRIG V(IN) VAL=lvdd2 TD=(meas_22tsw) RISE=0 TARG V(OUT) VAL=lvdd2 TD=(meas_22tsw) RISE=0
.meas tran tdel23 TRIG V(IN) VAL=lvdd2 TD=(meas_23tsw) RISE=0 TARG V(OUT) VAL=lvdd2 TD=(meas_23tsw) RISE=0
.meas tran tdel24 TRIG V(IN) VAL=lvdd2 TD=(meas_24tsw) RISE=0 TARG V(OUT) VAL=lvdd2 TD=(meas_24tsw) RISE=0
.meas tran tdel25 TRIG V(IN) VAL=lvdd2 TD=(meas_25tsw) RISE=0 TARG V(OUT) VAL=lvdd2 TD=(meas_25tsw) RISE=0
.meas tran tdel26 TRIG V(IN) VAL=lvdd2 TD=(meas_26tsw) RISE=0 TARG V(OUT) VAL=lvdd2 TD=(meas_26tsw) RISE=0
.meas tran tdel27 TRIG V(IN) VAL=lvdd2 TD=(meas_27tsw) RISE=0 TARG V(OUT) VAL=lvdd2 TD=(meas_27tsw) RISE=0
.meas tran tdel28 TRIG V(IN) VAL=lvdd2 TD=(meas_28tsw) RISE=0 TARG V(OUT) VAL=lvdd2 TD=(meas_28tsw) RISE=0
.meas tran tdel29 TRIG V(IN) VAL=lvdd2 TD=(meas_29tsw) RISE=0 TARG V(OUT) VAL=lvdd2 TD=(meas_29tsw) RISE=0
.meas tran tdel30 TRIG V(IN) VAL=lvdd2 TD=(meas_30tsw) RISE=0 TARG V(OUT) VAL=lvdd2 TD=(meas_30tsw) RISE=0
.meas tran tdel31 TRIG V(IN) VAL=lvdd2 TD=(meas_31tsw) RISE=0 TARG V(OUT) VAL=lvdd2 TD=(meas_31tsw) RISE=0
