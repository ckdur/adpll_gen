* Spice stub test_pll for transient simulations

.inc test_pll.sp

.TRAN 10n 'stopsim' uic
.SAVE
+    V(LOCKED)
+    V(ERR)
+    V(OUT)
+    V(REF)
+    V(RST_N)
+    V(OUT_DIV)
+    V(xpll.DCO_EN)
+    V(xpll.SS_BBPD_1_)
+    V(xpll.SS_BBPD_0_)
+    V(xpll.INJ_EDGE)
+    V(xpll.pll_ana_INJ_WIN)
+    V(xpll.COARSE_MUX_0_)
+    V(xpll.COARSE_MUX_1_)
+    V(xpll.COARSE_MUX_2_)
+    V(xpll.COARSE_MUX_3_)
+    V(xpll.COARSE_MUX_4_)
+    V(xpll.COARSE_MUX_5_)
+    V(xpll.COARSE_MUX_6_)
+    V(xpll.COARSE_MUX_7_)
+    V(xpll.COARSE_MUX_8_)
+    V(xpll.COARSE_MUX_9_)
+    V(xpll.COARSE_MUX_10_)
+    V(xpll.COARSE_MUX_11_)
+    V(xpll.COARSE_MUX_12_)
+    V(xpll.COARSE_MUX_13_)
+    V(xpll.COARSE_MUX_14_)
+    V(xpll.MID_MUX_0_)
+    V(xpll.MID_MUX_1_)
+    V(xpll.MID_MUX_2_)
+    V(xpll.MID_MUX_3_)
+    V(xpll.MID_MUX_4_)
+    V(xpll.MID_MUX_5_)
+    V(xpll.MID_MUX_6_)
+    V(xpll.MID_MUX_7_)
+    V(xpll.MID_MUX_8_)
+    V(xpll.MID_MUX_9_)
+    V(xpll.MID_MUX_10_)
+    V(xpll.MID_MUX_11_)
+    V(xpll.MID_MUX_12_)
+    V(xpll.MID_MUX_13_)
+    V(xpll.MID_MUX_14_)
+    V(xpll.FINE_MUX_0_)
+    V(xpll.FINE_MUX_1_)
+    V(xpll.FINE_MUX_2_)
+    V(xpll.FINE_MUX_3_)
+    V(xpll.FINE_MUX_4_)
+    V(xpll.FINE_MUX_5_)
+    V(xpll.FINE_MUX_6_)
+    V(xpll.FINE_MUX_7_)
+    V(xpll.FINE_MUX_8_)
+    V(xpll.FINE_MUX_9_)
+    V(xpll.FINE_MUX_10_)
+    V(xpll.FINE_MUX_11_)
+    V(xpll.FINE_MUX_12_)
+    V(xpll.FINE_MUX_13_)
+    V(xpll.FINE_MUX_14_)
+    V(xpll.FINE_MUX_15_)
+    V(xpll.FINE_MUX_16_)
+    V(xpll.FINE_MUX_17_)
+    V(xpll.FINE_MUX_18_)
+    V(xpll.FINE_MUX_19_)
+    V(xpll.FINE_MUX_20_)
+    V(xpll.FINE_MUX_21_)
+    V(xpll.FINE_MUX_22_)
+    V(xpll.FINE_MUX_23_)
+    V(xpll.FINE_MUX_24_)
+    V(xpll.FINE_MUX_25_)
+    V(xpll.FINE_MUX_26_)
+    V(xpll.FINE_MUX_27_)
+    V(xpll.FINE_MUX_28_)
+    V(xpll.FINE_MUX_29_)
+    V(xpll.FINE_MUX_30_)
+    V(xpll.pll_dig/flock_cnt_cap_0_)
+    V(xpll.pll_dig/flock_cnt_cap_1_)
+    V(xpll.pll_dig/flock_cnt_cap_2_)
+    V(xpll.pll_dig/flock_cnt_cap_3_)
+    V(xpll.pll_dig/flock_cnt_cap_4_)
+    V(xpll.pll_dig/flock_cnt_cap_5_)
+    V(xpll.pll_dig/flock_cnt_cap_6_)
+    V(xpll.pll_dig/flock_cnt_cap_7_)
+    V(xpll.pll_dig/flock_rst_cnt)
+    V(xpll.pll_dig/flock_cnt_0_)
+    V(xpll.pll_dig/flock_cnt_1_)
+    V(xpll.pll_dig/flock_cnt_2_)
+    V(xpll.pll_dig/flock_cnt_3_)
+    V(xpll.pll_dig/flock_cnt_4_)
+    V(xpll.pll_dig/flock_cnt_5_)
+    V(xpll.pll_dig/flock_cnt_6_)
+    V(xpll.pll_dig/flock_cnt_7_)

* Run and save the waveforms (.meas results are printed in the log)
.control
run
write test_pll_tran.raw
quit
.endc
