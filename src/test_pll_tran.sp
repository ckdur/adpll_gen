* Spice stub test_pll for transient simulations

.OPTION
+    ARTIST=2
+    INGOLD=2
+    PARHIER=LOCAL
+    PSF=2
+    PROBE

.inc test_pll.sp

.TRAN 10n stopsim uic
.PROBE
+    V(LOCKED)
+    V(ERR)
+    V(OUT)
+    V(REF)
+    V(RST_N)
+    V(OUT_DIV)
+    V(xpll.DCO_EN)
+    V(xpll.SS_BBPD[1])
+    V(xpll.SS_BBPD[0])
+    V(xpll.Xpll_ana.INJ_EDGE)
+    V(xpll.Xpll_ana.INJ_WIN)
+    V(xpll.COARSE_MUX[0])
+    V(xpll.COARSE_MUX[1])
+    V(xpll.COARSE_MUX[2])
+    V(xpll.COARSE_MUX[3])
+    V(xpll.COARSE_MUX[4])
+    V(xpll.COARSE_MUX[5])
+    V(xpll.COARSE_MUX[6])
+    V(xpll.COARSE_MUX[7])
+    V(xpll.COARSE_MUX[8])
+    V(xpll.COARSE_MUX[9])
+    V(xpll.COARSE_MUX[10])
+    V(xpll.COARSE_MUX[11])
+    V(xpll.COARSE_MUX[12])
+    V(xpll.COARSE_MUX[13])
+    V(xpll.COARSE_MUX[14])
+    V(xpll.MID_MUX[0])
+    V(xpll.MID_MUX[1])
+    V(xpll.MID_MUX[2])
+    V(xpll.MID_MUX[3])
+    V(xpll.MID_MUX[4])
+    V(xpll.MID_MUX[5])
+    V(xpll.MID_MUX[6])
+    V(xpll.MID_MUX[7])
+    V(xpll.MID_MUX[8])
+    V(xpll.MID_MUX[9])
+    V(xpll.MID_MUX[10])
+    V(xpll.MID_MUX[11])
+    V(xpll.MID_MUX[12])
+    V(xpll.MID_MUX[13])
+    V(xpll.MID_MUX[14])
+    V(xpll.FINE_MUX[0])
+    V(xpll.FINE_MUX[1])
+    V(xpll.FINE_MUX[2])
+    V(xpll.FINE_MUX[3])
+    V(xpll.FINE_MUX[4])
+    V(xpll.FINE_MUX[5])
+    V(xpll.FINE_MUX[6])
+    V(xpll.FINE_MUX[7])
+    V(xpll.FINE_MUX[8])
+    V(xpll.FINE_MUX[9])
+    V(xpll.FINE_MUX[10])
+    V(xpll.FINE_MUX[11])
+    V(xpll.FINE_MUX[12])
+    V(xpll.FINE_MUX[13])
+    V(xpll.FINE_MUX[14])
+    V(xpll.FINE_MUX[15])
+    V(xpll.FINE_MUX[16])
+    V(xpll.FINE_MUX[17])
+    V(xpll.FINE_MUX[18])
+    V(xpll.FINE_MUX[19])
+    V(xpll.FINE_MUX[20])
+    V(xpll.FINE_MUX[21])
+    V(xpll.FINE_MUX[22])
+    V(xpll.FINE_MUX[23])
+    V(xpll.FINE_MUX[24])
+    V(xpll.FINE_MUX[25])
+    V(xpll.FINE_MUX[26])
+    V(xpll.FINE_MUX[27])
+    V(xpll.FINE_MUX[28])
+    V(xpll.FINE_MUX[29])
+    V(xpll.FINE_MUX[30])
+    V(xpll.xlogic.flock_cnt_cap[0])
+    V(xpll.xlogic.flock_cnt_cap[1])
+    V(xpll.xlogic.flock_cnt_cap[2])
+    V(xpll.xlogic.flock_cnt_cap[3])
+    V(xpll.xlogic.flock_cnt_cap[4])
+    V(xpll.xlogic.flock_cnt_cap[5])
+    V(xpll.xlogic.flock_cnt_cap[6])
+    V(xpll.xlogic.flock_cnt_cap[7])
+    V(xpll.xlogic.flock_cnt_more)
+    V(xpll.xlogic.flock_cnt_less)
+    V(xpll.xlogic.flock_rst_cnt)
+    V(xpll.xlogic.flock_cnt[0])
+    V(xpll.xlogic.flock_cnt[1])
+    V(xpll.xlogic.flock_cnt[2])
+    V(xpll.xlogic.flock_cnt[3])
+    V(xpll.xlogic.flock_cnt[4])
+    V(xpll.xlogic.flock_cnt[5])
+    V(xpll.xlogic.flock_cnt[6])
+    V(xpll.xlogic.flock_cnt[7])
